* Folded Cascode OTA - AC Test (Template for 180nm)

.include '180nm_bulk.lib'

* Parameter mapping from 7nm FinFET to 180nm bulk
* nA parameters are lengths, nB parameters are converted from fins to width

V1 Vp GND DC 0.9 AC 0.2
V2 Vn GND DC 0.9 AC -0.2
C2 Vout GND 4p
C1 Vout net3 1p

* Simple folded cascode - mapping complex 7nm params to simple 180nm
M7 Vout net6 VDD VDD PMOS1 l={{nA1|default(0.25e-6)}} w={{nB1*0.18e-6|default(0.9e-6)}}
M6 Vout net3 GND GND NMOS1 l={{nA3|default(0.18e-6)}} w={{nB3*0.18e-6|default(0.54e-6)}}
M2 net3 Vp net1 VDD PMOS1 l={{nA2|default(0.28e-6)}} w={{nB2*0.18e-6|default(0.36e-6)}}
M1 net2 Vn net1 VDD PMOS1 l={{nA2|default(0.28e-6)}} w={{nB2*0.18e-6|default(0.36e-6)}}
M4 net3 net2 GND GND NMOS1 l={{nA4|default(0.42e-6)}} w={{nB4*0.18e-6|default(0.36e-6)}}
M3 net2 net2 GND GND NMOS1 l={{nA4|default(0.42e-6)}} w={{nB4*0.18e-6|default(0.36e-6)}}
M5 net1 net6 VDD VDD PMOS1 l={{nA5|default(0.32e-6)}} w={{nB5*0.18e-6|default(0.9e-6)}}
V0 VDD GND DC {{vdd|default(0.8)}}
M8 net6 net6 VDD VDD PMOS1 l={{nA6|default(0.45e-6)}} w={{nB6*0.18e-6|default(0.72e-6)}}
I1 net6 GND DC 10u

*.nodeset v(net1)=1.5 v(net2)=1.5 v(net3)=1.5

.ac dec 100 1k 100Meg

*.options numdgt=6 itl1=200 itl2=200

.control
set filetype=ascii
run
ac dec 100 1k 100Meg
print frequency v(vp) > ac_vp.txt
print frequency v(vn) > ac_vn.txt
print frequency v(vout) > ac_vout.txt
* Generate ac_out.txt with combined format expected by measurement script
echo "frequency voutp voutn" > ac_out.txt
print frequency v(vout) -v(vout) >> ac_out.txt
.endc

.end
